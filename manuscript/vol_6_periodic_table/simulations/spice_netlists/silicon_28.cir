* Applied Vacuum Engineering (AVE) - SPICE Netlist
* Element: Silicon-28 (Z=14, A=28)
* Auto-generated topological mutual impedance array
* Nodes: 28

* -----------------------------------------------------------------
* NUCLEON (Baseline 6^3_2 Topological Defect)
* -----------------------------------------------------------------
.SUBCKT NUCLEON IN OUT
L_CORE IN OUT 1uH
C_CORE IN OUT 1pF
.ENDS NUCLEON

* -----------------------------------------------------------------
* MACROSCOPIC TOPOLOGY (Nucleon Array)
* -----------------------------------------------------------------
V_STIM NODE_1 0 AC 1 PULSE(0 100k 10n 1n 1n 50n 100n)

X_NUC_1 NODE_1 0 NUCLEON
X_NUC_2 NODE_2 0 NUCLEON
X_NUC_3 NODE_3 0 NUCLEON
X_NUC_4 NODE_4 0 NUCLEON
X_NUC_5 NODE_5 0 NUCLEON
X_NUC_6 NODE_6 0 NUCLEON
X_NUC_7 NODE_7 0 NUCLEON
X_NUC_8 NODE_8 0 NUCLEON
X_NUC_9 NODE_9 0 NUCLEON
X_NUC_10 NODE_10 0 NUCLEON
X_NUC_11 NODE_11 0 NUCLEON
X_NUC_12 NODE_12 0 NUCLEON
X_NUC_13 NODE_13 0 NUCLEON
X_NUC_14 NODE_14 0 NUCLEON
X_NUC_15 NODE_15 0 NUCLEON
X_NUC_16 NODE_16 0 NUCLEON
X_NUC_17 NODE_17 0 NUCLEON
X_NUC_18 NODE_18 0 NUCLEON
X_NUC_19 NODE_19 0 NUCLEON
X_NUC_20 NODE_20 0 NUCLEON
X_NUC_21 NODE_21 0 NUCLEON
X_NUC_22 NODE_22 0 NUCLEON
X_NUC_23 NODE_23 0 NUCLEON
X_NUC_24 NODE_24 0 NUCLEON
X_NUC_25 NODE_25 0 NUCLEON
X_NUC_26 NODE_26 0 NUCLEON
X_NUC_27 NODE_27 0 NUCLEON
X_NUC_28 NODE_28 0 NUCLEON

* -----------------------------------------------------------------
* SPATIAL MUTUAL INDUCTANCE (K-FACTORS)
* -----------------------------------------------------------------
K_1 X_NUC_1.L_CORE X_NUC_2.L_CORE 0.210139
K_2 X_NUC_1.L_CORE X_NUC_3.L_CORE 0.210139
K_3 X_NUC_1.L_CORE X_NUC_4.L_CORE 0.210139
K_4 X_NUC_1.L_CORE X_NUC_5.L_CORE 0.003707
K_5 X_NUC_1.L_CORE X_NUC_6.L_CORE 0.003706
K_6 X_NUC_1.L_CORE X_NUC_7.L_CORE 0.003661
K_7 X_NUC_1.L_CORE X_NUC_8.L_CORE 0.003661
K_8 X_NUC_1.L_CORE X_NUC_9.L_CORE 0.005242
K_9 X_NUC_1.L_CORE X_NUC_10.L_CORE 0.005307
K_10 X_NUC_1.L_CORE X_NUC_11.L_CORE 0.005240
K_11 X_NUC_1.L_CORE X_NUC_12.L_CORE 0.005176
K_12 X_NUC_1.L_CORE X_NUC_13.L_CORE 0.005242
K_13 X_NUC_1.L_CORE X_NUC_14.L_CORE 0.005325
K_14 X_NUC_1.L_CORE X_NUC_15.L_CORE 0.005196
K_15 X_NUC_1.L_CORE X_NUC_16.L_CORE 0.005237
K_16 X_NUC_1.L_CORE X_NUC_17.L_CORE 0.005242
K_17 X_NUC_1.L_CORE X_NUC_18.L_CORE 0.005226
K_18 X_NUC_1.L_CORE X_NUC_19.L_CORE 0.005126
K_19 X_NUC_1.L_CORE X_NUC_20.L_CORE 0.005214
K_20 X_NUC_1.L_CORE X_NUC_21.L_CORE 0.005242
K_21 X_NUC_1.L_CORE X_NUC_22.L_CORE 0.005152
K_22 X_NUC_1.L_CORE X_NUC_23.L_CORE 0.005126
K_23 X_NUC_1.L_CORE X_NUC_24.L_CORE 0.005140
K_24 X_NUC_1.L_CORE X_NUC_25.L_CORE 0.005242
K_25 X_NUC_1.L_CORE X_NUC_26.L_CORE 0.005199
K_26 X_NUC_1.L_CORE X_NUC_27.L_CORE 0.005196
K_27 X_NUC_1.L_CORE X_NUC_28.L_CORE 0.005117
K_28 X_NUC_2.L_CORE X_NUC_3.L_CORE 0.210139
K_29 X_NUC_2.L_CORE X_NUC_4.L_CORE 0.210139
K_30 X_NUC_2.L_CORE X_NUC_5.L_CORE 0.003706
K_31 X_NUC_2.L_CORE X_NUC_6.L_CORE 0.003707
K_32 X_NUC_2.L_CORE X_NUC_7.L_CORE 0.003661
K_33 X_NUC_2.L_CORE X_NUC_8.L_CORE 0.003661
K_34 X_NUC_2.L_CORE X_NUC_9.L_CORE 0.005176
K_35 X_NUC_2.L_CORE X_NUC_10.L_CORE 0.005242
K_36 X_NUC_2.L_CORE X_NUC_11.L_CORE 0.005176
K_37 X_NUC_2.L_CORE X_NUC_12.L_CORE 0.005114
K_38 X_NUC_2.L_CORE X_NUC_13.L_CORE 0.005160
K_39 X_NUC_2.L_CORE X_NUC_14.L_CORE 0.005242
K_40 X_NUC_2.L_CORE X_NUC_15.L_CORE 0.005117
K_41 X_NUC_2.L_CORE X_NUC_16.L_CORE 0.005157
K_42 X_NUC_2.L_CORE X_NUC_17.L_CORE 0.005255
K_43 X_NUC_2.L_CORE X_NUC_18.L_CORE 0.005242
K_44 X_NUC_2.L_CORE X_NUC_19.L_CORE 0.005140
K_45 X_NUC_2.L_CORE X_NUC_20.L_CORE 0.005228
K_46 X_NUC_2.L_CORE X_NUC_21.L_CORE 0.005334
K_47 X_NUC_2.L_CORE X_NUC_22.L_CORE 0.005242
K_48 X_NUC_2.L_CORE X_NUC_23.L_CORE 0.005214
K_49 X_NUC_2.L_CORE X_NUC_24.L_CORE 0.005228
K_50 X_NUC_2.L_CORE X_NUC_25.L_CORE 0.005283
K_51 X_NUC_2.L_CORE X_NUC_26.L_CORE 0.005242
K_52 X_NUC_2.L_CORE X_NUC_27.L_CORE 0.005237
K_53 X_NUC_2.L_CORE X_NUC_28.L_CORE 0.005157
K_54 X_NUC_3.L_CORE X_NUC_4.L_CORE 0.210139
K_55 X_NUC_3.L_CORE X_NUC_5.L_CORE 0.003753
K_56 X_NUC_3.L_CORE X_NUC_6.L_CORE 0.003753
K_57 X_NUC_3.L_CORE X_NUC_7.L_CORE 0.003707
K_58 X_NUC_3.L_CORE X_NUC_8.L_CORE 0.003706
K_59 X_NUC_3.L_CORE X_NUC_9.L_CORE 0.005240
K_60 X_NUC_3.L_CORE X_NUC_10.L_CORE 0.005307
K_61 X_NUC_3.L_CORE X_NUC_11.L_CORE 0.005242
K_62 X_NUC_3.L_CORE X_NUC_12.L_CORE 0.005176
K_63 X_NUC_3.L_CORE X_NUC_13.L_CORE 0.005286
K_64 X_NUC_3.L_CORE X_NUC_14.L_CORE 0.005373
K_65 X_NUC_3.L_CORE X_NUC_15.L_CORE 0.005242
K_66 X_NUC_3.L_CORE X_NUC_16.L_CORE 0.005283
K_67 X_NUC_3.L_CORE X_NUC_17.L_CORE 0.005363
K_68 X_NUC_3.L_CORE X_NUC_18.L_CORE 0.005347
K_69 X_NUC_3.L_CORE X_NUC_19.L_CORE 0.005242
K_70 X_NUC_3.L_CORE X_NUC_20.L_CORE 0.005334
K_71 X_NUC_3.L_CORE X_NUC_21.L_CORE 0.005363
K_72 X_NUC_3.L_CORE X_NUC_22.L_CORE 0.005268
K_73 X_NUC_3.L_CORE X_NUC_23.L_CORE 0.005242
K_74 X_NUC_3.L_CORE X_NUC_24.L_CORE 0.005255
K_75 X_NUC_3.L_CORE X_NUC_25.L_CORE 0.005286
K_76 X_NUC_3.L_CORE X_NUC_26.L_CORE 0.005244
K_77 X_NUC_3.L_CORE X_NUC_27.L_CORE 0.005242
K_78 X_NUC_3.L_CORE X_NUC_28.L_CORE 0.005160
K_79 X_NUC_4.L_CORE X_NUC_5.L_CORE 0.003753
K_80 X_NUC_4.L_CORE X_NUC_6.L_CORE 0.003753
K_81 X_NUC_4.L_CORE X_NUC_7.L_CORE 0.003706
K_82 X_NUC_4.L_CORE X_NUC_8.L_CORE 0.003707
K_83 X_NUC_4.L_CORE X_NUC_9.L_CORE 0.005307
K_84 X_NUC_4.L_CORE X_NUC_10.L_CORE 0.005376
K_85 X_NUC_4.L_CORE X_NUC_11.L_CORE 0.005307
K_86 X_NUC_4.L_CORE X_NUC_12.L_CORE 0.005242
K_87 X_NUC_4.L_CORE X_NUC_13.L_CORE 0.005244
K_88 X_NUC_4.L_CORE X_NUC_14.L_CORE 0.005328
K_89 X_NUC_4.L_CORE X_NUC_15.L_CORE 0.005199
K_90 X_NUC_4.L_CORE X_NUC_16.L_CORE 0.005242
K_91 X_NUC_4.L_CORE X_NUC_17.L_CORE 0.005268
K_92 X_NUC_4.L_CORE X_NUC_18.L_CORE 0.005253
K_93 X_NUC_4.L_CORE X_NUC_19.L_CORE 0.005152
K_94 X_NUC_4.L_CORE X_NUC_20.L_CORE 0.005242
K_95 X_NUC_4.L_CORE X_NUC_21.L_CORE 0.005347
K_96 X_NUC_4.L_CORE X_NUC_22.L_CORE 0.005253
K_97 X_NUC_4.L_CORE X_NUC_23.L_CORE 0.005226
K_98 X_NUC_4.L_CORE X_NUC_24.L_CORE 0.005242
K_99 X_NUC_4.L_CORE X_NUC_25.L_CORE 0.005373
K_100 X_NUC_4.L_CORE X_NUC_26.L_CORE 0.005328
K_101 X_NUC_4.L_CORE X_NUC_27.L_CORE 0.005325
K_102 X_NUC_4.L_CORE X_NUC_28.L_CORE 0.005242
K_103 X_NUC_5.L_CORE X_NUC_6.L_CORE 0.210139
K_104 X_NUC_5.L_CORE X_NUC_7.L_CORE 0.210139
K_105 X_NUC_5.L_CORE X_NUC_8.L_CORE 0.210139
K_106 X_NUC_5.L_CORE X_NUC_9.L_CORE 0.005242
K_107 X_NUC_5.L_CORE X_NUC_10.L_CORE 0.005307
K_108 X_NUC_5.L_CORE X_NUC_11.L_CORE 0.005376
K_109 X_NUC_5.L_CORE X_NUC_12.L_CORE 0.005307
K_110 X_NUC_5.L_CORE X_NUC_13.L_CORE 0.005242
K_111 X_NUC_5.L_CORE X_NUC_14.L_CORE 0.005325
K_112 X_NUC_5.L_CORE X_NUC_15.L_CORE 0.005328
K_113 X_NUC_5.L_CORE X_NUC_16.L_CORE 0.005373
K_114 X_NUC_5.L_CORE X_NUC_17.L_CORE 0.005242
K_115 X_NUC_5.L_CORE X_NUC_18.L_CORE 0.005226
K_116 X_NUC_5.L_CORE X_NUC_19.L_CORE 0.005253
K_117 X_NUC_5.L_CORE X_NUC_20.L_CORE 0.005347
K_118 X_NUC_5.L_CORE X_NUC_21.L_CORE 0.005242
K_119 X_NUC_5.L_CORE X_NUC_22.L_CORE 0.005152
K_120 X_NUC_5.L_CORE X_NUC_23.L_CORE 0.005253
K_121 X_NUC_5.L_CORE X_NUC_24.L_CORE 0.005268
K_122 X_NUC_5.L_CORE X_NUC_25.L_CORE 0.005242
K_123 X_NUC_5.L_CORE X_NUC_26.L_CORE 0.005199
K_124 X_NUC_5.L_CORE X_NUC_27.L_CORE 0.005328
K_125 X_NUC_5.L_CORE X_NUC_28.L_CORE 0.005244
K_126 X_NUC_6.L_CORE X_NUC_7.L_CORE 0.210139
K_127 X_NUC_6.L_CORE X_NUC_8.L_CORE 0.210139
K_128 X_NUC_6.L_CORE X_NUC_9.L_CORE 0.005176
K_129 X_NUC_6.L_CORE X_NUC_10.L_CORE 0.005242
K_130 X_NUC_6.L_CORE X_NUC_11.L_CORE 0.005307
K_131 X_NUC_6.L_CORE X_NUC_12.L_CORE 0.005240
K_132 X_NUC_6.L_CORE X_NUC_13.L_CORE 0.005160
K_133 X_NUC_6.L_CORE X_NUC_14.L_CORE 0.005242
K_134 X_NUC_6.L_CORE X_NUC_15.L_CORE 0.005244
K_135 X_NUC_6.L_CORE X_NUC_16.L_CORE 0.005286
K_136 X_NUC_6.L_CORE X_NUC_17.L_CORE 0.005255
K_137 X_NUC_6.L_CORE X_NUC_18.L_CORE 0.005242
K_138 X_NUC_6.L_CORE X_NUC_19.L_CORE 0.005268
K_139 X_NUC_6.L_CORE X_NUC_20.L_CORE 0.005363
K_140 X_NUC_6.L_CORE X_NUC_21.L_CORE 0.005334
K_141 X_NUC_6.L_CORE X_NUC_22.L_CORE 0.005242
K_142 X_NUC_6.L_CORE X_NUC_23.L_CORE 0.005347
K_143 X_NUC_6.L_CORE X_NUC_24.L_CORE 0.005363
K_144 X_NUC_6.L_CORE X_NUC_25.L_CORE 0.005283
K_145 X_NUC_6.L_CORE X_NUC_26.L_CORE 0.005242
K_146 X_NUC_6.L_CORE X_NUC_27.L_CORE 0.005373
K_147 X_NUC_6.L_CORE X_NUC_28.L_CORE 0.005286
K_148 X_NUC_7.L_CORE X_NUC_8.L_CORE 0.210139
K_149 X_NUC_7.L_CORE X_NUC_9.L_CORE 0.005114
K_150 X_NUC_7.L_CORE X_NUC_10.L_CORE 0.005176
K_151 X_NUC_7.L_CORE X_NUC_11.L_CORE 0.005242
K_152 X_NUC_7.L_CORE X_NUC_12.L_CORE 0.005176
K_153 X_NUC_7.L_CORE X_NUC_13.L_CORE 0.005157
K_154 X_NUC_7.L_CORE X_NUC_14.L_CORE 0.005237
K_155 X_NUC_7.L_CORE X_NUC_15.L_CORE 0.005242
K_156 X_NUC_7.L_CORE X_NUC_16.L_CORE 0.005283
K_157 X_NUC_7.L_CORE X_NUC_17.L_CORE 0.005228
K_158 X_NUC_7.L_CORE X_NUC_18.L_CORE 0.005214
K_159 X_NUC_7.L_CORE X_NUC_19.L_CORE 0.005242
K_160 X_NUC_7.L_CORE X_NUC_20.L_CORE 0.005334
K_161 X_NUC_7.L_CORE X_NUC_21.L_CORE 0.005228
K_162 X_NUC_7.L_CORE X_NUC_22.L_CORE 0.005140
K_163 X_NUC_7.L_CORE X_NUC_23.L_CORE 0.005242
K_164 X_NUC_7.L_CORE X_NUC_24.L_CORE 0.005255
K_165 X_NUC_7.L_CORE X_NUC_25.L_CORE 0.005157
K_166 X_NUC_7.L_CORE X_NUC_26.L_CORE 0.005117
K_167 X_NUC_7.L_CORE X_NUC_27.L_CORE 0.005242
K_168 X_NUC_7.L_CORE X_NUC_28.L_CORE 0.005160
K_169 X_NUC_8.L_CORE X_NUC_9.L_CORE 0.005176
K_170 X_NUC_8.L_CORE X_NUC_10.L_CORE 0.005240
K_171 X_NUC_8.L_CORE X_NUC_11.L_CORE 0.005307
K_172 X_NUC_8.L_CORE X_NUC_12.L_CORE 0.005242
K_173 X_NUC_8.L_CORE X_NUC_13.L_CORE 0.005117
K_174 X_NUC_8.L_CORE X_NUC_14.L_CORE 0.005196
K_175 X_NUC_8.L_CORE X_NUC_15.L_CORE 0.005199
K_176 X_NUC_8.L_CORE X_NUC_16.L_CORE 0.005242
K_177 X_NUC_8.L_CORE X_NUC_17.L_CORE 0.005140
K_178 X_NUC_8.L_CORE X_NUC_18.L_CORE 0.005126
K_179 X_NUC_8.L_CORE X_NUC_19.L_CORE 0.005152
K_180 X_NUC_8.L_CORE X_NUC_20.L_CORE 0.005242
K_181 X_NUC_8.L_CORE X_NUC_21.L_CORE 0.005214
K_182 X_NUC_8.L_CORE X_NUC_22.L_CORE 0.005126
K_183 X_NUC_8.L_CORE X_NUC_23.L_CORE 0.005226
K_184 X_NUC_8.L_CORE X_NUC_24.L_CORE 0.005242
K_185 X_NUC_8.L_CORE X_NUC_25.L_CORE 0.005237
K_186 X_NUC_8.L_CORE X_NUC_26.L_CORE 0.005196
K_187 X_NUC_8.L_CORE X_NUC_27.L_CORE 0.005325
K_188 X_NUC_8.L_CORE X_NUC_28.L_CORE 0.005242
K_189 X_NUC_9.L_CORE X_NUC_10.L_CORE 0.210139
K_190 X_NUC_9.L_CORE X_NUC_11.L_CORE 0.210139
K_191 X_NUC_9.L_CORE X_NUC_12.L_CORE 0.210139
K_192 X_NUC_9.L_CORE X_NUC_13.L_CORE 0.006306
K_193 X_NUC_9.L_CORE X_NUC_14.L_CORE 0.006333
K_194 X_NUC_9.L_CORE X_NUC_15.L_CORE 0.006226
K_195 X_NUC_9.L_CORE X_NUC_16.L_CORE 0.006414
K_196 X_NUC_9.L_CORE X_NUC_17.L_CORE 0.003897
K_197 X_NUC_9.L_CORE X_NUC_18.L_CORE 0.003864
K_198 X_NUC_9.L_CORE X_NUC_19.L_CORE 0.003849
K_199 X_NUC_9.L_CORE X_NUC_20.L_CORE 0.003913
K_200 X_NUC_9.L_CORE X_NUC_21.L_CORE 0.003897
K_201 X_NUC_9.L_CORE X_NUC_22.L_CORE 0.003834
K_202 X_NUC_9.L_CORE X_NUC_23.L_CORE 0.003849
K_203 X_NUC_9.L_CORE X_NUC_24.L_CORE 0.003881
K_204 X_NUC_9.L_CORE X_NUC_25.L_CORE 0.006306
K_205 X_NUC_9.L_CORE X_NUC_26.L_CORE 0.006125
K_206 X_NUC_9.L_CORE X_NUC_27.L_CORE 0.006226
K_207 X_NUC_9.L_CORE X_NUC_28.L_CORE 0.006198
K_208 X_NUC_10.L_CORE X_NUC_11.L_CORE 0.210139
K_209 X_NUC_10.L_CORE X_NUC_12.L_CORE 0.210139
K_210 X_NUC_10.L_CORE X_NUC_13.L_CORE 0.006274
K_211 X_NUC_10.L_CORE X_NUC_14.L_CORE 0.006306
K_212 X_NUC_10.L_CORE X_NUC_15.L_CORE 0.006198
K_213 X_NUC_10.L_CORE X_NUC_16.L_CORE 0.006383
K_214 X_NUC_10.L_CORE X_NUC_17.L_CORE 0.003930
K_215 X_NUC_10.L_CORE X_NUC_18.L_CORE 0.003897
K_216 X_NUC_10.L_CORE X_NUC_19.L_CORE 0.003881
K_217 X_NUC_10.L_CORE X_NUC_20.L_CORE 0.003946
K_218 X_NUC_10.L_CORE X_NUC_21.L_CORE 0.003963
K_219 X_NUC_10.L_CORE X_NUC_22.L_CORE 0.003897
K_220 X_NUC_10.L_CORE X_NUC_23.L_CORE 0.003913
K_221 X_NUC_10.L_CORE X_NUC_24.L_CORE 0.003946
K_222 X_NUC_10.L_CORE X_NUC_25.L_CORE 0.006499
K_223 X_NUC_10.L_CORE X_NUC_26.L_CORE 0.006306
K_224 X_NUC_10.L_CORE X_NUC_27.L_CORE 0.006414
K_225 X_NUC_10.L_CORE X_NUC_28.L_CORE 0.006383
K_226 X_NUC_11.L_CORE X_NUC_12.L_CORE 0.210139
K_227 X_NUC_11.L_CORE X_NUC_13.L_CORE 0.006383
K_228 X_NUC_11.L_CORE X_NUC_14.L_CORE 0.006414
K_229 X_NUC_11.L_CORE X_NUC_15.L_CORE 0.006306
K_230 X_NUC_11.L_CORE X_NUC_16.L_CORE 0.006499
K_231 X_NUC_11.L_CORE X_NUC_17.L_CORE 0.003946
K_232 X_NUC_11.L_CORE X_NUC_18.L_CORE 0.003913
K_233 X_NUC_11.L_CORE X_NUC_19.L_CORE 0.003897
K_234 X_NUC_11.L_CORE X_NUC_20.L_CORE 0.003963
K_235 X_NUC_11.L_CORE X_NUC_21.L_CORE 0.003946
K_236 X_NUC_11.L_CORE X_NUC_22.L_CORE 0.003881
K_237 X_NUC_11.L_CORE X_NUC_23.L_CORE 0.003897
K_238 X_NUC_11.L_CORE X_NUC_24.L_CORE 0.003930
K_239 X_NUC_11.L_CORE X_NUC_25.L_CORE 0.006383
K_240 X_NUC_11.L_CORE X_NUC_26.L_CORE 0.006198
K_241 X_NUC_11.L_CORE X_NUC_27.L_CORE 0.006306
K_242 X_NUC_11.L_CORE X_NUC_28.L_CORE 0.006274
K_243 X_NUC_12.L_CORE X_NUC_13.L_CORE 0.006198
K_244 X_NUC_12.L_CORE X_NUC_14.L_CORE 0.006226
K_245 X_NUC_12.L_CORE X_NUC_15.L_CORE 0.006125
K_246 X_NUC_12.L_CORE X_NUC_16.L_CORE 0.006306
K_247 X_NUC_12.L_CORE X_NUC_17.L_CORE 0.003881
K_248 X_NUC_12.L_CORE X_NUC_18.L_CORE 0.003849
K_249 X_NUC_12.L_CORE X_NUC_19.L_CORE 0.003834
K_250 X_NUC_12.L_CORE X_NUC_20.L_CORE 0.003897
K_251 X_NUC_12.L_CORE X_NUC_21.L_CORE 0.003913
K_252 X_NUC_12.L_CORE X_NUC_22.L_CORE 0.003849
K_253 X_NUC_12.L_CORE X_NUC_23.L_CORE 0.003864
K_254 X_NUC_12.L_CORE X_NUC_24.L_CORE 0.003897
K_255 X_NUC_12.L_CORE X_NUC_25.L_CORE 0.006414
K_256 X_NUC_12.L_CORE X_NUC_26.L_CORE 0.006226
K_257 X_NUC_12.L_CORE X_NUC_27.L_CORE 0.006333
K_258 X_NUC_12.L_CORE X_NUC_28.L_CORE 0.006306
K_259 X_NUC_13.L_CORE X_NUC_14.L_CORE 0.210139
K_260 X_NUC_13.L_CORE X_NUC_15.L_CORE 0.210139
K_261 X_NUC_13.L_CORE X_NUC_16.L_CORE 0.210139
K_262 X_NUC_13.L_CORE X_NUC_17.L_CORE 0.006306
K_263 X_NUC_13.L_CORE X_NUC_18.L_CORE 0.006141
K_264 X_NUC_13.L_CORE X_NUC_19.L_CORE 0.006180
K_265 X_NUC_13.L_CORE X_NUC_20.L_CORE 0.006262
K_266 X_NUC_13.L_CORE X_NUC_21.L_CORE 0.003897
K_267 X_NUC_13.L_CORE X_NUC_22.L_CORE 0.003827
K_268 X_NUC_13.L_CORE X_NUC_23.L_CORE 0.003867
K_269 X_NUC_13.L_CORE X_NUC_24.L_CORE 0.003856
K_270 X_NUC_13.L_CORE X_NUC_25.L_CORE 0.003897
K_271 X_NUC_13.L_CORE X_NUC_26.L_CORE 0.003847
K_272 X_NUC_13.L_CORE X_NUC_27.L_CORE 0.003897
K_273 X_NUC_13.L_CORE X_NUC_28.L_CORE 0.003847
K_274 X_NUC_14.L_CORE X_NUC_15.L_CORE 0.210139
K_275 X_NUC_14.L_CORE X_NUC_16.L_CORE 0.210139
K_276 X_NUC_14.L_CORE X_NUC_17.L_CORE 0.006479
K_277 X_NUC_14.L_CORE X_NUC_18.L_CORE 0.006306
K_278 X_NUC_14.L_CORE X_NUC_19.L_CORE 0.006345
K_279 X_NUC_14.L_CORE X_NUC_20.L_CORE 0.006434
K_280 X_NUC_14.L_CORE X_NUC_21.L_CORE 0.003970
K_281 X_NUC_14.L_CORE X_NUC_22.L_CORE 0.003897
K_282 X_NUC_14.L_CORE X_NUC_23.L_CORE 0.003939
K_283 X_NUC_14.L_CORE X_NUC_24.L_CORE 0.003927
K_284 X_NUC_14.L_CORE X_NUC_25.L_CORE 0.003949
K_285 X_NUC_14.L_CORE X_NUC_26.L_CORE 0.003897
K_286 X_NUC_14.L_CORE X_NUC_27.L_CORE 0.003949
K_287 X_NUC_14.L_CORE X_NUC_28.L_CORE 0.003897
K_288 X_NUC_15.L_CORE X_NUC_16.L_CORE 0.210139
K_289 X_NUC_15.L_CORE X_NUC_17.L_CORE 0.006434
K_290 X_NUC_15.L_CORE X_NUC_18.L_CORE 0.006262
K_291 X_NUC_15.L_CORE X_NUC_19.L_CORE 0.006306
K_292 X_NUC_15.L_CORE X_NUC_20.L_CORE 0.006391
K_293 X_NUC_15.L_CORE X_NUC_21.L_CORE 0.003927
K_294 X_NUC_15.L_CORE X_NUC_22.L_CORE 0.003856
K_295 X_NUC_15.L_CORE X_NUC_23.L_CORE 0.003897
K_296 X_NUC_15.L_CORE X_NUC_24.L_CORE 0.003886
K_297 X_NUC_15.L_CORE X_NUC_25.L_CORE 0.003897
K_298 X_NUC_15.L_CORE X_NUC_26.L_CORE 0.003847
K_299 X_NUC_15.L_CORE X_NUC_27.L_CORE 0.003897
K_300 X_NUC_15.L_CORE X_NUC_28.L_CORE 0.003847
K_301 X_NUC_16.L_CORE X_NUC_17.L_CORE 0.006345
K_302 X_NUC_16.L_CORE X_NUC_18.L_CORE 0.006180
K_303 X_NUC_16.L_CORE X_NUC_19.L_CORE 0.006219
K_304 X_NUC_16.L_CORE X_NUC_20.L_CORE 0.006306
K_305 X_NUC_16.L_CORE X_NUC_21.L_CORE 0.003939
K_306 X_NUC_16.L_CORE X_NUC_22.L_CORE 0.003867
K_307 X_NUC_16.L_CORE X_NUC_23.L_CORE 0.003908
K_308 X_NUC_16.L_CORE X_NUC_24.L_CORE 0.003897
K_309 X_NUC_16.L_CORE X_NUC_25.L_CORE 0.003949
K_310 X_NUC_16.L_CORE X_NUC_26.L_CORE 0.003897
K_311 X_NUC_16.L_CORE X_NUC_27.L_CORE 0.003949
K_312 X_NUC_16.L_CORE X_NUC_28.L_CORE 0.003897
K_313 X_NUC_17.L_CORE X_NUC_18.L_CORE 0.210139
K_314 X_NUC_17.L_CORE X_NUC_19.L_CORE 0.210139
K_315 X_NUC_17.L_CORE X_NUC_20.L_CORE 0.210139
K_316 X_NUC_17.L_CORE X_NUC_21.L_CORE 0.006306
K_317 X_NUC_17.L_CORE X_NUC_22.L_CORE 0.006174
K_318 X_NUC_17.L_CORE X_NUC_23.L_CORE 0.006303
K_319 X_NUC_17.L_CORE X_NUC_24.L_CORE 0.006174
K_320 X_NUC_17.L_CORE X_NUC_25.L_CORE 0.003897
K_321 X_NUC_17.L_CORE X_NUC_26.L_CORE 0.003886
K_322 X_NUC_17.L_CORE X_NUC_27.L_CORE 0.003927
K_323 X_NUC_17.L_CORE X_NUC_28.L_CORE 0.003856
K_324 X_NUC_18.L_CORE X_NUC_19.L_CORE 0.210139
K_325 X_NUC_18.L_CORE X_NUC_20.L_CORE 0.210139
K_326 X_NUC_18.L_CORE X_NUC_21.L_CORE 0.006441
K_327 X_NUC_18.L_CORE X_NUC_22.L_CORE 0.006306
K_328 X_NUC_18.L_CORE X_NUC_23.L_CORE 0.006441
K_329 X_NUC_18.L_CORE X_NUC_24.L_CORE 0.006303
K_330 X_NUC_18.L_CORE X_NUC_25.L_CORE 0.003908
K_331 X_NUC_18.L_CORE X_NUC_26.L_CORE 0.003897
K_332 X_NUC_18.L_CORE X_NUC_27.L_CORE 0.003939
K_333 X_NUC_18.L_CORE X_NUC_28.L_CORE 0.003867
K_334 X_NUC_19.L_CORE X_NUC_20.L_CORE 0.210139
K_335 X_NUC_19.L_CORE X_NUC_21.L_CORE 0.006303
K_336 X_NUC_19.L_CORE X_NUC_22.L_CORE 0.006174
K_337 X_NUC_19.L_CORE X_NUC_23.L_CORE 0.006306
K_338 X_NUC_19.L_CORE X_NUC_24.L_CORE 0.006174
K_339 X_NUC_19.L_CORE X_NUC_25.L_CORE 0.003867
K_340 X_NUC_19.L_CORE X_NUC_26.L_CORE 0.003856
K_341 X_NUC_19.L_CORE X_NUC_27.L_CORE 0.003897
K_342 X_NUC_19.L_CORE X_NUC_28.L_CORE 0.003827
K_343 X_NUC_20.L_CORE X_NUC_21.L_CORE 0.006441
K_344 X_NUC_20.L_CORE X_NUC_22.L_CORE 0.006303
K_345 X_NUC_20.L_CORE X_NUC_23.L_CORE 0.006441
K_346 X_NUC_20.L_CORE X_NUC_24.L_CORE 0.006306
K_347 X_NUC_20.L_CORE X_NUC_25.L_CORE 0.003939
K_348 X_NUC_20.L_CORE X_NUC_26.L_CORE 0.003927
K_349 X_NUC_20.L_CORE X_NUC_27.L_CORE 0.003970
K_350 X_NUC_20.L_CORE X_NUC_28.L_CORE 0.003897
K_351 X_NUC_21.L_CORE X_NUC_22.L_CORE 0.210139
K_352 X_NUC_21.L_CORE X_NUC_23.L_CORE 0.210139
K_353 X_NUC_21.L_CORE X_NUC_24.L_CORE 0.210139
K_354 X_NUC_21.L_CORE X_NUC_25.L_CORE 0.006306
K_355 X_NUC_21.L_CORE X_NUC_26.L_CORE 0.006391
K_356 X_NUC_21.L_CORE X_NUC_27.L_CORE 0.006434
K_357 X_NUC_21.L_CORE X_NUC_28.L_CORE 0.006262
K_358 X_NUC_22.L_CORE X_NUC_23.L_CORE 0.210139
K_359 X_NUC_22.L_CORE X_NUC_24.L_CORE 0.210139
K_360 X_NUC_22.L_CORE X_NUC_25.L_CORE 0.006219
K_361 X_NUC_22.L_CORE X_NUC_26.L_CORE 0.006306
K_362 X_NUC_22.L_CORE X_NUC_27.L_CORE 0.006345
K_363 X_NUC_22.L_CORE X_NUC_28.L_CORE 0.006180
K_364 X_NUC_23.L_CORE X_NUC_24.L_CORE 0.210139
K_365 X_NUC_23.L_CORE X_NUC_25.L_CORE 0.006180
K_366 X_NUC_23.L_CORE X_NUC_26.L_CORE 0.006262
K_367 X_NUC_23.L_CORE X_NUC_27.L_CORE 0.006306
K_368 X_NUC_23.L_CORE X_NUC_28.L_CORE 0.006141
K_369 X_NUC_24.L_CORE X_NUC_25.L_CORE 0.006345
K_370 X_NUC_24.L_CORE X_NUC_26.L_CORE 0.006434
K_371 X_NUC_24.L_CORE X_NUC_27.L_CORE 0.006479
K_372 X_NUC_24.L_CORE X_NUC_28.L_CORE 0.006306
K_373 X_NUC_25.L_CORE X_NUC_26.L_CORE 0.210139
K_374 X_NUC_25.L_CORE X_NUC_27.L_CORE 0.210139
K_375 X_NUC_25.L_CORE X_NUC_28.L_CORE 0.210139
K_376 X_NUC_26.L_CORE X_NUC_27.L_CORE 0.210139
K_377 X_NUC_26.L_CORE X_NUC_28.L_CORE 0.210139
K_378 X_NUC_27.L_CORE X_NUC_28.L_CORE 0.210139

* -----------------------------------------------------------------
* SIMULATION DIRECTIVES
* -----------------------------------------------------------------
* Transient Analysis: 100kV Step Pulse (1ns rise) to test dielectric rupture limits
.TRAN 0.1n 200n
* Broadband AC sweep: 1 MHz to 1 GHz to ping macro-resonance Q-factors
.AC DEC 100 1MEG 1G
.OPTIONS METHOD=GEAR

.END
