* Applied Vacuum Engineering (AVE) - SPICE Netlist
* Element: Carbon-12 (Z=6, A=12)
* Auto-generated topological mutual impedance array
* Nodes: 12

* -----------------------------------------------------------------
* NUCLEON (Baseline 6^3_2 Topological Defect)
* -----------------------------------------------------------------
.SUBCKT NUCLEON IN OUT
L_CORE IN OUT 1uH
C_CORE IN OUT 1pF
.ENDS NUCLEON

* -----------------------------------------------------------------
* MACROSCOPIC TOPOLOGY (Nucleon Array)
* -----------------------------------------------------------------
V_STIM NODE_1 0 AC 1 PULSE(0 100k 10n 1n 1n 50n 100n)

X_NUC_1 NODE_1 0 NUCLEON
X_NUC_2 NODE_2 0 NUCLEON
X_NUC_3 NODE_3 0 NUCLEON
X_NUC_4 NODE_4 0 NUCLEON
X_NUC_5 NODE_5 0 NUCLEON
X_NUC_6 NODE_6 0 NUCLEON
X_NUC_7 NODE_7 0 NUCLEON
X_NUC_8 NODE_8 0 NUCLEON
X_NUC_9 NODE_9 0 NUCLEON
X_NUC_10 NODE_10 0 NUCLEON
X_NUC_11 NODE_11 0 NUCLEON
X_NUC_12 NODE_12 0 NUCLEON

* -----------------------------------------------------------------
* SPATIAL MUTUAL INDUCTANCE (K-FACTORS)
* -----------------------------------------------------------------
K_1 X_NUC_1.L_CORE X_NUC_2.L_CORE 0.210139
K_2 X_NUC_1.L_CORE X_NUC_3.L_CORE 0.210139
K_3 X_NUC_1.L_CORE X_NUC_4.L_CORE 0.210139
K_4 X_NUC_1.L_CORE X_NUC_5.L_CORE 0.006831
K_5 X_NUC_1.L_CORE X_NUC_6.L_CORE 0.006771
K_6 X_NUC_1.L_CORE X_NUC_7.L_CORE 0.006695
K_7 X_NUC_1.L_CORE X_NUC_8.L_CORE 0.006907
K_8 X_NUC_1.L_CORE X_NUC_9.L_CORE 0.006831
K_9 X_NUC_1.L_CORE X_NUC_10.L_CORE 0.006623
K_10 X_NUC_1.L_CORE X_NUC_11.L_CORE 0.006695
K_11 X_NUC_1.L_CORE X_NUC_12.L_CORE 0.006750
K_12 X_NUC_2.L_CORE X_NUC_3.L_CORE 0.210139
K_13 X_NUC_2.L_CORE X_NUC_4.L_CORE 0.210139
K_14 X_NUC_2.L_CORE X_NUC_5.L_CORE 0.006885
K_15 X_NUC_2.L_CORE X_NUC_6.L_CORE 0.006831
K_16 X_NUC_2.L_CORE X_NUC_7.L_CORE 0.006750
K_17 X_NUC_2.L_CORE X_NUC_8.L_CORE 0.006967
K_18 X_NUC_2.L_CORE X_NUC_9.L_CORE 0.007052
K_19 X_NUC_2.L_CORE X_NUC_10.L_CORE 0.006831
K_20 X_NUC_2.L_CORE X_NUC_11.L_CORE 0.006907
K_21 X_NUC_2.L_CORE X_NUC_12.L_CORE 0.006967
K_22 X_NUC_3.L_CORE X_NUC_4.L_CORE 0.210139
K_23 X_NUC_3.L_CORE X_NUC_5.L_CORE 0.006967
K_24 X_NUC_3.L_CORE X_NUC_6.L_CORE 0.006907
K_25 X_NUC_3.L_CORE X_NUC_7.L_CORE 0.006831
K_26 X_NUC_3.L_CORE X_NUC_8.L_CORE 0.007052
K_27 X_NUC_3.L_CORE X_NUC_9.L_CORE 0.006967
K_28 X_NUC_3.L_CORE X_NUC_10.L_CORE 0.006750
K_29 X_NUC_3.L_CORE X_NUC_11.L_CORE 0.006831
K_30 X_NUC_3.L_CORE X_NUC_12.L_CORE 0.006885
K_31 X_NUC_4.L_CORE X_NUC_5.L_CORE 0.006750
K_32 X_NUC_4.L_CORE X_NUC_6.L_CORE 0.006695
K_33 X_NUC_4.L_CORE X_NUC_7.L_CORE 0.006623
K_34 X_NUC_4.L_CORE X_NUC_8.L_CORE 0.006831
K_35 X_NUC_4.L_CORE X_NUC_9.L_CORE 0.006907
K_36 X_NUC_4.L_CORE X_NUC_10.L_CORE 0.006695
K_37 X_NUC_4.L_CORE X_NUC_11.L_CORE 0.006771
K_38 X_NUC_4.L_CORE X_NUC_12.L_CORE 0.006831
K_39 X_NUC_5.L_CORE X_NUC_6.L_CORE 0.210139
K_40 X_NUC_5.L_CORE X_NUC_7.L_CORE 0.210139
K_41 X_NUC_5.L_CORE X_NUC_8.L_CORE 0.210139
K_42 X_NUC_5.L_CORE X_NUC_9.L_CORE 0.006831
K_43 X_NUC_5.L_CORE X_NUC_10.L_CORE 0.006676
K_44 X_NUC_5.L_CORE X_NUC_11.L_CORE 0.006827
K_45 X_NUC_5.L_CORE X_NUC_12.L_CORE 0.006676
K_46 X_NUC_6.L_CORE X_NUC_7.L_CORE 0.210139
K_47 X_NUC_6.L_CORE X_NUC_8.L_CORE 0.210139
K_48 X_NUC_6.L_CORE X_NUC_9.L_CORE 0.006990
K_49 X_NUC_6.L_CORE X_NUC_10.L_CORE 0.006831
K_50 X_NUC_6.L_CORE X_NUC_11.L_CORE 0.006990
K_51 X_NUC_6.L_CORE X_NUC_12.L_CORE 0.006827
K_52 X_NUC_7.L_CORE X_NUC_8.L_CORE 0.210139
K_53 X_NUC_7.L_CORE X_NUC_9.L_CORE 0.006827
K_54 X_NUC_7.L_CORE X_NUC_10.L_CORE 0.006676
K_55 X_NUC_7.L_CORE X_NUC_11.L_CORE 0.006831
K_56 X_NUC_7.L_CORE X_NUC_12.L_CORE 0.006676
K_57 X_NUC_8.L_CORE X_NUC_9.L_CORE 0.006990
K_58 X_NUC_8.L_CORE X_NUC_10.L_CORE 0.006827
K_59 X_NUC_8.L_CORE X_NUC_11.L_CORE 0.006990
K_60 X_NUC_8.L_CORE X_NUC_12.L_CORE 0.006831
K_61 X_NUC_9.L_CORE X_NUC_10.L_CORE 0.210139
K_62 X_NUC_9.L_CORE X_NUC_11.L_CORE 0.210139
K_63 X_NUC_9.L_CORE X_NUC_12.L_CORE 0.210139
K_64 X_NUC_10.L_CORE X_NUC_11.L_CORE 0.210139
K_65 X_NUC_10.L_CORE X_NUC_12.L_CORE 0.210139
K_66 X_NUC_11.L_CORE X_NUC_12.L_CORE 0.210139

* -----------------------------------------------------------------
* SIMULATION DIRECTIVES
* -----------------------------------------------------------------
* Transient Analysis: 100kV Step Pulse (1ns rise) to test dielectric rupture limits
.TRAN 0.1n 200n
* Broadband AC sweep: 1 MHz to 1 GHz to ping macro-resonance Q-factors
.AC DEC 100 1MEG 1G
.OPTIONS METHOD=GEAR

.END
