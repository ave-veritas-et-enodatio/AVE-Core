* Applied Vacuum Engineering (AVE) - SPICE Netlist
* Element: Sodium-23 (Z=11, A=23)
* Auto-generated topological mutual impedance array
* Nodes: 23

* -----------------------------------------------------------------
* NUCLEON (Baseline 6^3_2 Topological Defect)
* -----------------------------------------------------------------
.SUBCKT NUCLEON IN OUT
L_CORE IN OUT 1uH
C_CORE IN OUT 1pF
.ENDS NUCLEON

* -----------------------------------------------------------------
* MACROSCOPIC TOPOLOGY (Nucleon Array)
* -----------------------------------------------------------------
V_STIM NODE_1 0 AC 1 PULSE(0 100k 10n 1n 1n 50n 100n)

X_NUC_1 NODE_1 0 NUCLEON
X_NUC_2 NODE_2 0 NUCLEON
X_NUC_3 NODE_3 0 NUCLEON
X_NUC_4 NODE_4 0 NUCLEON
X_NUC_5 NODE_5 0 NUCLEON
X_NUC_6 NODE_6 0 NUCLEON
X_NUC_7 NODE_7 0 NUCLEON
X_NUC_8 NODE_8 0 NUCLEON
X_NUC_9 NODE_9 0 NUCLEON
X_NUC_10 NODE_10 0 NUCLEON
X_NUC_11 NODE_11 0 NUCLEON
X_NUC_12 NODE_12 0 NUCLEON
X_NUC_13 NODE_13 0 NUCLEON
X_NUC_14 NODE_14 0 NUCLEON
X_NUC_15 NODE_15 0 NUCLEON
X_NUC_16 NODE_16 0 NUCLEON
X_NUC_17 NODE_17 0 NUCLEON
X_NUC_18 NODE_18 0 NUCLEON
X_NUC_19 NODE_19 0 NUCLEON
X_NUC_20 NODE_20 0 NUCLEON
X_NUC_21 NODE_21 0 NUCLEON
X_NUC_22 NODE_22 0 NUCLEON
X_NUC_23 NODE_23 0 NUCLEON

* -----------------------------------------------------------------
* SPATIAL MUTUAL INDUCTANCE (K-FACTORS)
* -----------------------------------------------------------------
K_1 X_NUC_1.L_CORE X_NUC_2.L_CORE 0.210139
K_2 X_NUC_1.L_CORE X_NUC_3.L_CORE 0.210139
K_3 X_NUC_1.L_CORE X_NUC_4.L_CORE 0.210139
K_4 X_NUC_1.L_CORE X_NUC_5.L_CORE 0.003768
K_5 X_NUC_1.L_CORE X_NUC_6.L_CORE 0.003768
K_6 X_NUC_1.L_CORE X_NUC_7.L_CORE 0.003721
K_7 X_NUC_1.L_CORE X_NUC_8.L_CORE 0.003721
K_8 X_NUC_1.L_CORE X_NUC_9.L_CORE 0.005329
K_9 X_NUC_1.L_CORE X_NUC_10.L_CORE 0.005396
K_10 X_NUC_1.L_CORE X_NUC_11.L_CORE 0.005328
K_11 X_NUC_1.L_CORE X_NUC_12.L_CORE 0.005261
K_12 X_NUC_1.L_CORE X_NUC_13.L_CORE 0.005329
K_13 X_NUC_1.L_CORE X_NUC_14.L_CORE 0.005353
K_14 X_NUC_1.L_CORE X_NUC_15.L_CORE 0.005229
K_15 X_NUC_1.L_CORE X_NUC_16.L_CORE 0.005319
K_16 X_NUC_1.L_CORE X_NUC_17.L_CORE 0.005329
K_17 X_NUC_1.L_CORE X_NUC_18.L_CORE 0.005238
K_18 X_NUC_1.L_CORE X_NUC_19.L_CORE 0.005229
K_19 X_NUC_1.L_CORE X_NUC_20.L_CORE 0.005206
K_20 X_NUC_1.L_CORE X_NUC_21.L_CORE 0.011844
K_21 X_NUC_1.L_CORE X_NUC_22.L_CORE 0.011835
K_22 X_NUC_1.L_CORE X_NUC_23.L_CORE 0.012333
K_23 X_NUC_2.L_CORE X_NUC_3.L_CORE 0.210139
K_24 X_NUC_2.L_CORE X_NUC_4.L_CORE 0.210139
K_25 X_NUC_2.L_CORE X_NUC_5.L_CORE 0.003768
K_26 X_NUC_2.L_CORE X_NUC_6.L_CORE 0.003768
K_27 X_NUC_2.L_CORE X_NUC_7.L_CORE 0.003721
K_28 X_NUC_2.L_CORE X_NUC_8.L_CORE 0.003721
K_29 X_NUC_2.L_CORE X_NUC_9.L_CORE 0.005261
K_30 X_NUC_2.L_CORE X_NUC_10.L_CORE 0.005329
K_31 X_NUC_2.L_CORE X_NUC_11.L_CORE 0.005261
K_32 X_NUC_2.L_CORE X_NUC_12.L_CORE 0.005198
K_33 X_NUC_2.L_CORE X_NUC_13.L_CORE 0.005303
K_34 X_NUC_2.L_CORE X_NUC_14.L_CORE 0.005329
K_35 X_NUC_2.L_CORE X_NUC_15.L_CORE 0.005206
K_36 X_NUC_2.L_CORE X_NUC_16.L_CORE 0.005294
K_37 X_NUC_2.L_CORE X_NUC_17.L_CORE 0.005422
K_38 X_NUC_2.L_CORE X_NUC_18.L_CORE 0.005329
K_39 X_NUC_2.L_CORE X_NUC_19.L_CORE 0.005319
K_40 X_NUC_2.L_CORE X_NUC_20.L_CORE 0.005294
K_41 X_NUC_2.L_CORE X_NUC_21.L_CORE 0.011835
K_42 X_NUC_2.L_CORE X_NUC_22.L_CORE 0.011844
K_43 X_NUC_2.L_CORE X_NUC_23.L_CORE 0.012333
K_44 X_NUC_3.L_CORE X_NUC_4.L_CORE 0.210139
K_45 X_NUC_3.L_CORE X_NUC_5.L_CORE 0.003817
K_46 X_NUC_3.L_CORE X_NUC_6.L_CORE 0.003817
K_47 X_NUC_3.L_CORE X_NUC_7.L_CORE 0.003768
K_48 X_NUC_3.L_CORE X_NUC_8.L_CORE 0.003768
K_49 X_NUC_3.L_CORE X_NUC_9.L_CORE 0.005328
K_50 X_NUC_3.L_CORE X_NUC_10.L_CORE 0.005396
K_51 X_NUC_3.L_CORE X_NUC_11.L_CORE 0.005329
K_52 X_NUC_3.L_CORE X_NUC_12.L_CORE 0.005261
K_53 X_NUC_3.L_CORE X_NUC_13.L_CORE 0.005432
K_54 X_NUC_3.L_CORE X_NUC_14.L_CORE 0.005458
K_55 X_NUC_3.L_CORE X_NUC_15.L_CORE 0.005329
K_56 X_NUC_3.L_CORE X_NUC_16.L_CORE 0.005422
K_57 X_NUC_3.L_CORE X_NUC_17.L_CORE 0.005432
K_58 X_NUC_3.L_CORE X_NUC_18.L_CORE 0.005337
K_59 X_NUC_3.L_CORE X_NUC_19.L_CORE 0.005329
K_60 X_NUC_3.L_CORE X_NUC_20.L_CORE 0.005303
K_61 X_NUC_3.L_CORE X_NUC_21.L_CORE 0.011391
K_62 X_NUC_3.L_CORE X_NUC_22.L_CORE 0.011382
K_63 X_NUC_3.L_CORE X_NUC_23.L_CORE 0.011842
K_64 X_NUC_4.L_CORE X_NUC_5.L_CORE 0.003817
K_65 X_NUC_4.L_CORE X_NUC_6.L_CORE 0.003817
K_66 X_NUC_4.L_CORE X_NUC_7.L_CORE 0.003768
K_67 X_NUC_4.L_CORE X_NUC_8.L_CORE 0.003768
K_68 X_NUC_4.L_CORE X_NUC_9.L_CORE 0.005396
K_69 X_NUC_4.L_CORE X_NUC_10.L_CORE 0.005468
K_70 X_NUC_4.L_CORE X_NUC_11.L_CORE 0.005396
K_71 X_NUC_4.L_CORE X_NUC_12.L_CORE 0.005329
K_72 X_NUC_4.L_CORE X_NUC_13.L_CORE 0.005337
K_73 X_NUC_4.L_CORE X_NUC_14.L_CORE 0.005362
K_74 X_NUC_4.L_CORE X_NUC_15.L_CORE 0.005238
K_75 X_NUC_4.L_CORE X_NUC_16.L_CORE 0.005329
K_76 X_NUC_4.L_CORE X_NUC_17.L_CORE 0.005458
K_77 X_NUC_4.L_CORE X_NUC_18.L_CORE 0.005362
K_78 X_NUC_4.L_CORE X_NUC_19.L_CORE 0.005353
K_79 X_NUC_4.L_CORE X_NUC_20.L_CORE 0.005329
K_80 X_NUC_4.L_CORE X_NUC_21.L_CORE 0.011382
K_81 X_NUC_4.L_CORE X_NUC_22.L_CORE 0.011391
K_82 X_NUC_4.L_CORE X_NUC_23.L_CORE 0.011842
K_83 X_NUC_5.L_CORE X_NUC_6.L_CORE 0.210139
K_84 X_NUC_5.L_CORE X_NUC_7.L_CORE 0.210139
K_85 X_NUC_5.L_CORE X_NUC_8.L_CORE 0.210139
K_86 X_NUC_5.L_CORE X_NUC_9.L_CORE 0.005329
K_87 X_NUC_5.L_CORE X_NUC_10.L_CORE 0.005396
K_88 X_NUC_5.L_CORE X_NUC_11.L_CORE 0.005468
K_89 X_NUC_5.L_CORE X_NUC_12.L_CORE 0.005396
K_90 X_NUC_5.L_CORE X_NUC_13.L_CORE 0.005329
K_91 X_NUC_5.L_CORE X_NUC_14.L_CORE 0.005353
K_92 X_NUC_5.L_CORE X_NUC_15.L_CORE 0.005362
K_93 X_NUC_5.L_CORE X_NUC_16.L_CORE 0.005458
K_94 X_NUC_5.L_CORE X_NUC_17.L_CORE 0.005329
K_95 X_NUC_5.L_CORE X_NUC_18.L_CORE 0.005238
K_96 X_NUC_5.L_CORE X_NUC_19.L_CORE 0.005362
K_97 X_NUC_5.L_CORE X_NUC_20.L_CORE 0.005337
K_98 X_NUC_5.L_CORE X_NUC_21.L_CORE 0.002859
K_99 X_NUC_5.L_CORE X_NUC_22.L_CORE 0.002859
K_100 X_NUC_5.L_CORE X_NUC_23.L_CORE 0.002887
K_101 X_NUC_6.L_CORE X_NUC_7.L_CORE 0.210139
K_102 X_NUC_6.L_CORE X_NUC_8.L_CORE 0.210139
K_103 X_NUC_6.L_CORE X_NUC_9.L_CORE 0.005261
K_104 X_NUC_6.L_CORE X_NUC_10.L_CORE 0.005329
K_105 X_NUC_6.L_CORE X_NUC_11.L_CORE 0.005396
K_106 X_NUC_6.L_CORE X_NUC_12.L_CORE 0.005328
K_107 X_NUC_6.L_CORE X_NUC_13.L_CORE 0.005303
K_108 X_NUC_6.L_CORE X_NUC_14.L_CORE 0.005329
K_109 X_NUC_6.L_CORE X_NUC_15.L_CORE 0.005337
K_110 X_NUC_6.L_CORE X_NUC_16.L_CORE 0.005432
K_111 X_NUC_6.L_CORE X_NUC_17.L_CORE 0.005422
K_112 X_NUC_6.L_CORE X_NUC_18.L_CORE 0.005329
K_113 X_NUC_6.L_CORE X_NUC_19.L_CORE 0.005458
K_114 X_NUC_6.L_CORE X_NUC_20.L_CORE 0.005432
K_115 X_NUC_6.L_CORE X_NUC_21.L_CORE 0.002859
K_116 X_NUC_6.L_CORE X_NUC_22.L_CORE 0.002859
K_117 X_NUC_6.L_CORE X_NUC_23.L_CORE 0.002887
K_118 X_NUC_7.L_CORE X_NUC_8.L_CORE 0.210139
K_119 X_NUC_7.L_CORE X_NUC_9.L_CORE 0.005198
K_120 X_NUC_7.L_CORE X_NUC_10.L_CORE 0.005261
K_121 X_NUC_7.L_CORE X_NUC_11.L_CORE 0.005329
K_122 X_NUC_7.L_CORE X_NUC_12.L_CORE 0.005261
K_123 X_NUC_7.L_CORE X_NUC_13.L_CORE 0.005294
K_124 X_NUC_7.L_CORE X_NUC_14.L_CORE 0.005319
K_125 X_NUC_7.L_CORE X_NUC_15.L_CORE 0.005329
K_126 X_NUC_7.L_CORE X_NUC_16.L_CORE 0.005422
K_127 X_NUC_7.L_CORE X_NUC_17.L_CORE 0.005294
K_128 X_NUC_7.L_CORE X_NUC_18.L_CORE 0.005206
K_129 X_NUC_7.L_CORE X_NUC_19.L_CORE 0.005329
K_130 X_NUC_7.L_CORE X_NUC_20.L_CORE 0.005303
K_131 X_NUC_7.L_CORE X_NUC_21.L_CORE 0.002832
K_132 X_NUC_7.L_CORE X_NUC_22.L_CORE 0.002832
K_133 X_NUC_7.L_CORE X_NUC_23.L_CORE 0.002859
K_134 X_NUC_8.L_CORE X_NUC_9.L_CORE 0.005261
K_135 X_NUC_8.L_CORE X_NUC_10.L_CORE 0.005328
K_136 X_NUC_8.L_CORE X_NUC_11.L_CORE 0.005396
K_137 X_NUC_8.L_CORE X_NUC_12.L_CORE 0.005329
K_138 X_NUC_8.L_CORE X_NUC_13.L_CORE 0.005206
K_139 X_NUC_8.L_CORE X_NUC_14.L_CORE 0.005229
K_140 X_NUC_8.L_CORE X_NUC_15.L_CORE 0.005238
K_141 X_NUC_8.L_CORE X_NUC_16.L_CORE 0.005329
K_142 X_NUC_8.L_CORE X_NUC_17.L_CORE 0.005319
K_143 X_NUC_8.L_CORE X_NUC_18.L_CORE 0.005229
K_144 X_NUC_8.L_CORE X_NUC_19.L_CORE 0.005353
K_145 X_NUC_8.L_CORE X_NUC_20.L_CORE 0.005329
K_146 X_NUC_8.L_CORE X_NUC_21.L_CORE 0.002832
K_147 X_NUC_8.L_CORE X_NUC_22.L_CORE 0.002832
K_148 X_NUC_8.L_CORE X_NUC_23.L_CORE 0.002859
K_149 X_NUC_9.L_CORE X_NUC_10.L_CORE 0.210139
K_150 X_NUC_9.L_CORE X_NUC_11.L_CORE 0.210139
K_151 X_NUC_9.L_CORE X_NUC_12.L_CORE 0.210139
K_152 X_NUC_9.L_CORE X_NUC_13.L_CORE 0.004351
K_153 X_NUC_9.L_CORE X_NUC_14.L_CORE 0.004327
K_154 X_NUC_9.L_CORE X_NUC_15.L_CORE 0.004296
K_155 X_NUC_9.L_CORE X_NUC_16.L_CORE 0.004383
K_156 X_NUC_9.L_CORE X_NUC_17.L_CORE 0.004351
K_157 X_NUC_9.L_CORE X_NUC_18.L_CORE 0.004266
K_158 X_NUC_9.L_CORE X_NUC_19.L_CORE 0.004296
K_159 X_NUC_9.L_CORE X_NUC_20.L_CORE 0.004319
K_160 X_NUC_9.L_CORE X_NUC_21.L_CORE 0.003917
K_161 X_NUC_9.L_CORE X_NUC_22.L_CORE 0.003916
K_162 X_NUC_9.L_CORE X_NUC_23.L_CORE 0.003961
K_163 X_NUC_10.L_CORE X_NUC_11.L_CORE 0.210139
K_164 X_NUC_10.L_CORE X_NUC_12.L_CORE 0.210139
K_165 X_NUC_10.L_CORE X_NUC_13.L_CORE 0.004374
K_166 X_NUC_10.L_CORE X_NUC_14.L_CORE 0.004351
K_167 X_NUC_10.L_CORE X_NUC_15.L_CORE 0.004319
K_168 X_NUC_10.L_CORE X_NUC_16.L_CORE 0.004407
K_169 X_NUC_10.L_CORE X_NUC_17.L_CORE 0.004440
K_170 X_NUC_10.L_CORE X_NUC_18.L_CORE 0.004351
K_171 X_NUC_10.L_CORE X_NUC_19.L_CORE 0.004383
K_172 X_NUC_10.L_CORE X_NUC_20.L_CORE 0.004407
K_173 X_NUC_10.L_CORE X_NUC_21.L_CORE 0.003944
K_174 X_NUC_10.L_CORE X_NUC_22.L_CORE 0.003944
K_175 X_NUC_10.L_CORE X_NUC_23.L_CORE 0.003989
K_176 X_NUC_11.L_CORE X_NUC_12.L_CORE 0.210139
K_177 X_NUC_11.L_CORE X_NUC_13.L_CORE 0.004407
K_178 X_NUC_11.L_CORE X_NUC_14.L_CORE 0.004383
K_179 X_NUC_11.L_CORE X_NUC_15.L_CORE 0.004351
K_180 X_NUC_11.L_CORE X_NUC_16.L_CORE 0.004440
K_181 X_NUC_11.L_CORE X_NUC_17.L_CORE 0.004407
K_182 X_NUC_11.L_CORE X_NUC_18.L_CORE 0.004319
K_183 X_NUC_11.L_CORE X_NUC_19.L_CORE 0.004351
K_184 X_NUC_11.L_CORE X_NUC_20.L_CORE 0.004374
K_185 X_NUC_11.L_CORE X_NUC_21.L_CORE 0.003900
K_186 X_NUC_11.L_CORE X_NUC_22.L_CORE 0.003899
K_187 X_NUC_11.L_CORE X_NUC_23.L_CORE 0.003944
K_188 X_NUC_12.L_CORE X_NUC_13.L_CORE 0.004319
K_189 X_NUC_12.L_CORE X_NUC_14.L_CORE 0.004296
K_190 X_NUC_12.L_CORE X_NUC_15.L_CORE 0.004266
K_191 X_NUC_12.L_CORE X_NUC_16.L_CORE 0.004351
K_192 X_NUC_12.L_CORE X_NUC_17.L_CORE 0.004383
K_193 X_NUC_12.L_CORE X_NUC_18.L_CORE 0.004296
K_194 X_NUC_12.L_CORE X_NUC_19.L_CORE 0.004327
K_195 X_NUC_12.L_CORE X_NUC_20.L_CORE 0.004351
K_196 X_NUC_12.L_CORE X_NUC_21.L_CORE 0.003873
K_197 X_NUC_12.L_CORE X_NUC_22.L_CORE 0.003873
K_198 X_NUC_12.L_CORE X_NUC_23.L_CORE 0.003917
K_199 X_NUC_13.L_CORE X_NUC_14.L_CORE 0.210139
K_200 X_NUC_13.L_CORE X_NUC_15.L_CORE 0.210139
K_201 X_NUC_13.L_CORE X_NUC_16.L_CORE 0.210139
K_202 X_NUC_13.L_CORE X_NUC_17.L_CORE 0.004351
K_203 X_NUC_13.L_CORE X_NUC_18.L_CORE 0.004288
K_204 X_NUC_13.L_CORE X_NUC_19.L_CORE 0.004350
K_205 X_NUC_13.L_CORE X_NUC_20.L_CORE 0.004288
K_206 X_NUC_13.L_CORE X_NUC_21.L_CORE 0.003937
K_207 X_NUC_13.L_CORE X_NUC_22.L_CORE 0.003913
K_208 X_NUC_13.L_CORE X_NUC_23.L_CORE 0.003970
K_209 X_NUC_14.L_CORE X_NUC_15.L_CORE 0.210139
K_210 X_NUC_14.L_CORE X_NUC_16.L_CORE 0.210139
K_211 X_NUC_14.L_CORE X_NUC_17.L_CORE 0.004416
K_212 X_NUC_14.L_CORE X_NUC_18.L_CORE 0.004351
K_213 X_NUC_14.L_CORE X_NUC_19.L_CORE 0.004416
K_214 X_NUC_14.L_CORE X_NUC_20.L_CORE 0.004350
K_215 X_NUC_14.L_CORE X_NUC_21.L_CORE 0.003947
K_216 X_NUC_14.L_CORE X_NUC_22.L_CORE 0.003924
K_217 X_NUC_14.L_CORE X_NUC_23.L_CORE 0.003980
K_218 X_NUC_15.L_CORE X_NUC_16.L_CORE 0.210139
K_219 X_NUC_15.L_CORE X_NUC_17.L_CORE 0.004350
K_220 X_NUC_15.L_CORE X_NUC_18.L_CORE 0.004288
K_221 X_NUC_15.L_CORE X_NUC_19.L_CORE 0.004351
K_222 X_NUC_15.L_CORE X_NUC_20.L_CORE 0.004288
K_223 X_NUC_15.L_CORE X_NUC_21.L_CORE 0.003880
K_224 X_NUC_15.L_CORE X_NUC_22.L_CORE 0.003857
K_225 X_NUC_15.L_CORE X_NUC_23.L_CORE 0.003912
K_226 X_NUC_16.L_CORE X_NUC_17.L_CORE 0.004416
K_227 X_NUC_16.L_CORE X_NUC_18.L_CORE 0.004350
K_228 X_NUC_16.L_CORE X_NUC_19.L_CORE 0.004416
K_229 X_NUC_16.L_CORE X_NUC_20.L_CORE 0.004351
K_230 X_NUC_16.L_CORE X_NUC_21.L_CORE 0.003916
K_231 X_NUC_16.L_CORE X_NUC_22.L_CORE 0.003893
K_232 X_NUC_16.L_CORE X_NUC_23.L_CORE 0.003949
K_233 X_NUC_17.L_CORE X_NUC_18.L_CORE 0.210139
K_234 X_NUC_17.L_CORE X_NUC_19.L_CORE 0.210139
K_235 X_NUC_17.L_CORE X_NUC_20.L_CORE 0.210139
K_236 X_NUC_17.L_CORE X_NUC_21.L_CORE 0.003937
K_237 X_NUC_17.L_CORE X_NUC_22.L_CORE 0.003961
K_238 X_NUC_17.L_CORE X_NUC_23.L_CORE 0.003994
K_239 X_NUC_18.L_CORE X_NUC_19.L_CORE 0.210139
K_240 X_NUC_18.L_CORE X_NUC_20.L_CORE 0.210139
K_241 X_NUC_18.L_CORE X_NUC_21.L_CORE 0.003900
K_242 X_NUC_18.L_CORE X_NUC_22.L_CORE 0.003924
K_243 X_NUC_18.L_CORE X_NUC_23.L_CORE 0.003956
K_244 X_NUC_19.L_CORE X_NUC_20.L_CORE 0.210139
K_245 X_NUC_19.L_CORE X_NUC_21.L_CORE 0.003880
K_246 X_NUC_19.L_CORE X_NUC_22.L_CORE 0.003902
K_247 X_NUC_19.L_CORE X_NUC_23.L_CORE 0.003935
K_248 X_NUC_20.L_CORE X_NUC_21.L_CORE 0.003870
K_249 X_NUC_20.L_CORE X_NUC_22.L_CORE 0.003893
K_250 X_NUC_20.L_CORE X_NUC_23.L_CORE 0.003925
K_251 X_NUC_21.L_CORE X_NUC_22.L_CORE 0.297182
K_252 X_NUC_21.L_CORE X_NUC_23.L_CORE 0.265808
K_253 X_NUC_22.L_CORE X_NUC_23.L_CORE 0.265808

* -----------------------------------------------------------------
* SIMULATION DIRECTIVES
* -----------------------------------------------------------------
* Transient Analysis: 100kV Step Pulse (1ns rise) to test dielectric rupture limits
.TRAN 0.1n 200n
* Broadband AC sweep: 1 MHz to 1 GHz to ping macro-resonance Q-factors
.AC DEC 100 1MEG 1G
.OPTIONS METHOD=GEAR

.END
