* EE Bench Dielectric Yield Plateau — AVE DC Sweep
* Generated by ave.solvers.spice_netlist_compiler
*
.INCLUDE /Users/grantlindblom/Applied-Vacuum-Engineering/src/ave/hardware/spice_models/ave_vacuum_cell.lib

* DC sweep source
V_SWEEP N_GAP GND DC 0

* Universal vacuum cell (varactor only)
X1 N_GAP GND AVE_EE_BENCH C0=1.000000e-11 V_YLD=43653.7

* Parasitic shunt for DC convergence
R_PAR N_GAP GND 1G

.DC V_SWEEP 0 45000 100

.control
run
* Plot C_eff / C0 = d(charge)/dV / C0
plot deriv(i(V_SWEEP)) / 1.000000e-11 title 'C_eff/C0 vs V'
.endc

.END
