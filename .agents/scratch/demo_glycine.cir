* AVE Amino Acid SPICE Model: Glycine
* Generated by ave.solvers.spice_netlist_compiler
*
.INCLUDE /Users/grantlindblom/Applied-Vacuum-Engineering/src/ave/hardware/spice_models/ave_vacuum_cell.lib

* AC excitation source (1V amplitude)
V_SRC N_IN GND AC 1

* ── Network topology ──
X0 N_terminal CA AVE_VACUUM_CELL L0=2.300000e-18 C0=1.200000e-24 R0=0.000000e+00 V_YLD=43653.7 I_YMAX=124.4
X1 CA C_carboxyl AVE_VACUUM_CELL L0=1.900000e-18 C0=1.400000e-24 R0=0.000000e+00 V_YLD=43653.7 I_YMAX=124.4
X2 C_carboxyl O AVE_VACUUM_CELL L0=2.600000e-18 C0=1.000000e-24 R0=0.000000e+00 V_YLD=43653.7 I_YMAX=124.4

* ── Shunt loads ──
R_TERM O GND 50

.AC DEC 500 1.000000e+12 1.000000e+14

.control
run
plot db(V(O)) title 'Transfer Function (dB)'
.endc

.END
