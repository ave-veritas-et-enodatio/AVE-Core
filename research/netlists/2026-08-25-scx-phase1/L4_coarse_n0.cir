* L4/OBS-4 srs supercell L=2 (N=64, B=96), periodic wrap
*
* SCX Phase-1 external-solver cross-check. CLASS: IMPLEMENTATION-VERIFICATION.
* Prereg (FROZEN): research/2026-08-25_solver-crosscheck-phase1_prereg-FROZEN.md
* GO gate: _orchestration/docket-entries/2026-08-24-ruling-r56-scx-trades.md (R56)
* Emitted by: src/ave/solvers/scx_spice_export.py
*
* SECTOR: MODE numerical-infrastructure / REGIME I cold sub-yield lossless-reactive
*         (A=0, S(A)=1, Op14 off) / PHASE-STATE cold crystalline quiescent /
*         CHANNEL scalar-translational ONLY / CARRIER srs-z3.
*
* CANONICAL SOURCE: src/ave/core/constants.py (resolved and asserted by assert_canonical_source())
*
* IMPORTED SYMBOLS (nothing below is typed; every value enters by import):
*   Z_0                      = 376.73031346177066  ohm     [ave.core.constants]
*   OMEGA_C                  = 7.76344071105011e+20  rad/s   [ave.core.constants]
*   ANALYTIC_NETWORK_FACTOR  = 0.5773502691896258          [ave.core.chiral_lattice_dynamics]
*   L_CELL                   = 4.85262047439289e-19  H       [ave.core.constants]
*   C_CELL                   = 3.41912668394556e-24  F       [ave.core.constants]
*
* DELAY CONVENTION EMITTED: R2   (R56 item 2 pins R2 for the exporter;
*   the corpus's physics-level R1-vs-R2 flag, srs-band-structure.md:157
*   'Flagged for adjudication', STAYS OPEN -- this label is an engineering
*   convention on the emitted netlist, NOT a physics adjudication.)
*   R2  TD = ANALYTIC_NETWORK_FACTOR/OMEGA_C = 7.436783388682972e-22 s
*   R1  TD = ell_node/c_0                    = 1.2880886674083153e-21 s
*   III TD = sqrt(3)*ell_node/c_0            = 2.231035016604891e-21 s
*   EMITTED TD                               = 7.436783388682972e-22 s
*
* UNITS SCALING: SI   (T6; the observables are dimensionless ratios,
*   so this cannot move a verdict -- it is a conditioning/readability choice.)
*
* GRAPH: 64 nodes, 96 bonds, drive at n0
*
I_drv 0 n0 AC 1
T0 n0 0 n37 0 Z0=376.73031346177066 TD=7.436783388682972e-22
T1 n0 0 n22 0 Z0=376.73031346177066 TD=7.436783388682972e-22
T2 n0 0 n15 0 Z0=376.73031346177066 TD=7.436783388682972e-22
T3 n1 0 n14 0 Z0=376.73031346177066 TD=7.436783388682972e-22
T4 n1 0 n7 0 Z0=376.73031346177066 TD=7.436783388682972e-22
T5 n1 0 n4 0 Z0=376.73031346177066 TD=7.436783388682972e-22
T6 n2 0 n39 0 Z0=376.73031346177066 TD=7.436783388682972e-22
T7 n2 0 n4 0 Z0=376.73031346177066 TD=7.436783388682972e-22
T8 n2 0 n5 0 Z0=376.73031346177066 TD=7.436783388682972e-22
T9 n3 0 n6 0 Z0=376.73031346177066 TD=7.436783388682972e-22
T10 n3 0 n21 0 Z0=376.73031346177066 TD=7.436783388682972e-22
T11 n3 0 n4 0 Z0=376.73031346177066 TD=7.436783388682972e-22
T12 n5 0 n19 0 Z0=376.73031346177066 TD=7.436783388682972e-22
T13 n5 0 n32 0 Z0=376.73031346177066 TD=7.436783388682972e-22
T14 n6 0 n16 0 Z0=376.73031346177066 TD=7.436783388682972e-22
T15 n6 0 n9 0 Z0=376.73031346177066 TD=7.436783388682972e-22
T16 n7 0 n34 0 Z0=376.73031346177066 TD=7.436783388682972e-22
T17 n7 0 n8 0 Z0=376.73031346177066 TD=7.436783388682972e-22
T18 n8 0 n45 0 Z0=376.73031346177066 TD=7.436783388682972e-22
T19 n8 0 n30 0 Z0=376.73031346177066 TD=7.436783388682972e-22
T20 n9 0 n12 0 Z0=376.73031346177066 TD=7.436783388682972e-22
T21 n9 0 n15 0 Z0=376.73031346177066 TD=7.436783388682972e-22
T22 n10 0 n47 0 Z0=376.73031346177066 TD=7.436783388682972e-22
T23 n10 0 n12 0 Z0=376.73031346177066 TD=7.436783388682972e-22
T24 n10 0 n13 0 Z0=376.73031346177066 TD=7.436783388682972e-22
T25 n11 0 n14 0 Z0=376.73031346177066 TD=7.436783388682972e-22
T26 n11 0 n29 0 Z0=376.73031346177066 TD=7.436783388682972e-22
T27 n11 0 n12 0 Z0=376.73031346177066 TD=7.436783388682972e-22
T28 n13 0 n27 0 Z0=376.73031346177066 TD=7.436783388682972e-22
T29 n13 0 n40 0 Z0=376.73031346177066 TD=7.436783388682972e-22
T30 n14 0 n24 0 Z0=376.73031346177066 TD=7.436783388682972e-22
T31 n15 0 n42 0 Z0=376.73031346177066 TD=7.436783388682972e-22
T32 n16 0 n31 0 Z0=376.73031346177066 TD=7.436783388682972e-22
T33 n16 0 n53 0 Z0=376.73031346177066 TD=7.436783388682972e-22
T34 n17 0 n30 0 Z0=376.73031346177066 TD=7.436783388682972e-22
T35 n17 0 n23 0 Z0=376.73031346177066 TD=7.436783388682972e-22
T36 n17 0 n20 0 Z0=376.73031346177066 TD=7.436783388682972e-22
T37 n18 0 n21 0 Z0=376.73031346177066 TD=7.436783388682972e-22
T38 n18 0 n55 0 Z0=376.73031346177066 TD=7.436783388682972e-22
T39 n18 0 n20 0 Z0=376.73031346177066 TD=7.436783388682972e-22
T40 n19 0 n20 0 Z0=376.73031346177066 TD=7.436783388682972e-22
T41 n19 0 n22 0 Z0=376.73031346177066 TD=7.436783388682972e-22
T42 n21 0 n48 0 Z0=376.73031346177066 TD=7.436783388682972e-22
T43 n22 0 n25 0 Z0=376.73031346177066 TD=7.436783388682972e-22
T44 n23 0 n24 0 Z0=376.73031346177066 TD=7.436783388682972e-22
T45 n23 0 n50 0 Z0=376.73031346177066 TD=7.436783388682972e-22
T46 n24 0 n61 0 Z0=376.73031346177066 TD=7.436783388682972e-22
T47 n25 0 n31 0 Z0=376.73031346177066 TD=7.436783388682972e-22
T48 n25 0 n28 0 Z0=376.73031346177066 TD=7.436783388682972e-22
T49 n26 0 n63 0 Z0=376.73031346177066 TD=7.436783388682972e-22
T50 n26 0 n29 0 Z0=376.73031346177066 TD=7.436783388682972e-22
T51 n26 0 n28 0 Z0=376.73031346177066 TD=7.436783388682972e-22
T52 n27 0 n28 0 Z0=376.73031346177066 TD=7.436783388682972e-22
T53 n27 0 n30 0 Z0=376.73031346177066 TD=7.436783388682972e-22
T54 n29 0 n56 0 Z0=376.73031346177066 TD=7.436783388682972e-22
T55 n31 0 n58 0 Z0=376.73031346177066 TD=7.436783388682972e-22
T56 n32 0 n54 0 Z0=376.73031346177066 TD=7.436783388682972e-22
T57 n32 0 n47 0 Z0=376.73031346177066 TD=7.436783388682972e-22
T58 n33 0 n36 0 Z0=376.73031346177066 TD=7.436783388682972e-22
T59 n33 0 n46 0 Z0=376.73031346177066 TD=7.436783388682972e-22
T60 n33 0 n39 0 Z0=376.73031346177066 TD=7.436783388682972e-22
T61 n34 0 n37 0 Z0=376.73031346177066 TD=7.436783388682972e-22
T62 n34 0 n36 0 Z0=376.73031346177066 TD=7.436783388682972e-22
T63 n35 0 n53 0 Z0=376.73031346177066 TD=7.436783388682972e-22
T64 n35 0 n36 0 Z0=376.73031346177066 TD=7.436783388682972e-22
T65 n35 0 n38 0 Z0=376.73031346177066 TD=7.436783388682972e-22
T66 n37 0 n51 0 Z0=376.73031346177066 TD=7.436783388682972e-22
T67 n38 0 n48 0 Z0=376.73031346177066 TD=7.436783388682972e-22
T68 n38 0 n41 0 Z0=376.73031346177066 TD=7.436783388682972e-22
T69 n39 0 n40 0 Z0=376.73031346177066 TD=7.436783388682972e-22
T70 n40 0 n62 0 Z0=376.73031346177066 TD=7.436783388682972e-22
T71 n41 0 n44 0 Z0=376.73031346177066 TD=7.436783388682972e-22
T72 n41 0 n47 0 Z0=376.73031346177066 TD=7.436783388682972e-22
T73 n42 0 n45 0 Z0=376.73031346177066 TD=7.436783388682972e-22
T74 n42 0 n44 0 Z0=376.73031346177066 TD=7.436783388682972e-22
T75 n43 0 n46 0 Z0=376.73031346177066 TD=7.436783388682972e-22
T76 n43 0 n61 0 Z0=376.73031346177066 TD=7.436783388682972e-22
T77 n43 0 n44 0 Z0=376.73031346177066 TD=7.436783388682972e-22
T78 n45 0 n59 0 Z0=376.73031346177066 TD=7.436783388682972e-22
T79 n46 0 n56 0 Z0=376.73031346177066 TD=7.436783388682972e-22
T80 n48 0 n63 0 Z0=376.73031346177066 TD=7.436783388682972e-22
T81 n49 0 n62 0 Z0=376.73031346177066 TD=7.436783388682972e-22
T82 n49 0 n55 0 Z0=376.73031346177066 TD=7.436783388682972e-22
T83 n49 0 n52 0 Z0=376.73031346177066 TD=7.436783388682972e-22
T84 n50 0 n52 0 Z0=376.73031346177066 TD=7.436783388682972e-22
T85 n50 0 n53 0 Z0=376.73031346177066 TD=7.436783388682972e-22
T86 n51 0 n52 0 Z0=376.73031346177066 TD=7.436783388682972e-22
T87 n51 0 n54 0 Z0=376.73031346177066 TD=7.436783388682972e-22
T88 n54 0 n57 0 Z0=376.73031346177066 TD=7.436783388682972e-22
T89 n55 0 n56 0 Z0=376.73031346177066 TD=7.436783388682972e-22
T90 n57 0 n63 0 Z0=376.73031346177066 TD=7.436783388682972e-22
T91 n57 0 n60 0 Z0=376.73031346177066 TD=7.436783388682972e-22
T92 n58 0 n60 0 Z0=376.73031346177066 TD=7.436783388682972e-22
T93 n58 0 n61 0 Z0=376.73031346177066 TD=7.436783388682972e-22
T94 n59 0 n60 0 Z0=376.73031346177066 TD=7.436783388682972e-22
T95 n59 0 n62 0 Z0=376.73031346177066 TD=7.436783388682972e-22
.control
set numdgt=17
set filetype=ascii
set wr_singlescale
ac lin 20001 6.723336876543721e+17 7.059503720370907e+20
wrdata L4_coarse_n0.dat v(n0)
.endc
.end
