* SPICE-lane pilot — resistor-network Poisson (.OP)
* Cross-checks src/scripts/vol_4_engineering/spice_lane_pilot_poisson.py
*
R0 0 N1 655.550049
R1 N1 N2 377.683623
R2 N2 N3 297.673879
R3 N3 N4 561.115625
R4 N4 N5 588.226532
R5 N5 N6 778.823240
R6 N6 N7 752.023522
R7 N7 N8 351.263841
R8 N8 N9 131.916005
R9 N9 N10 424.541240
R10 N10 N11 391.387863
R11 N11 N12 240.174563
R12 N12 N13 449.334783
R13 N13 N14 840.946122
R14 N14 N15 55.215564
R15 N15 N16 690.091841
R16 N16 N17 94.401768
R17 N17 N18 56.931386
R18 N18 N19 454.580890
R19 N19 N20 330.535416
R20 N20 N21 455.145447
R21 N21 N22 83.450384
R22 N22 N23 193.940256
R23 N12 N18 790.797758
R24 N20 N5 869.187406
R25 N5 N17 64.057978
R26 N19 N17 726.867324
R27 N1 N19 654.772421
R28 N4 N13 152.858751
R29 N12 N13 994.047375
R30 N4 N8 855.870059
R31 N13 N1 149.970775
I_inj23 0 N23 DC 0.001000
.OP
.control
run
print all
.endc
.END
