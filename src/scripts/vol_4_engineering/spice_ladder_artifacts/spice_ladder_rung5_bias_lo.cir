* SPICE PHASE-1 rung 5 — biased LC-varactor ladder small-signal
* 40 cells, L=1.000000e-06 H, C0=1.000000e-09 F, V_bias=0.0000 V
* S(V_bias)=1.000000  C_eff=C0/S^3=1.000000e-09 F  Zc=31.6228 ohm
VB BIAS 0 DC 0.000000
V1 SRC BIAS DC 0 AC 1
Rs SRC NA 31.622777
CA NA 0 Q = {1.000000e-09 * V(NA) / sqrt(1 - min((V(NA)/510998.949996)**2, 0.9999))}
L0 NA N1 1.000000e-06
C1 N1 0 Q = {1.000000e-09 * V(N1) / sqrt(1 - min((V(N1)/510998.949996)**2, 0.9999))}
L1 N1 N2 1.000000e-06
C2 N2 0 Q = {1.000000e-09 * V(N2) / sqrt(1 - min((V(N2)/510998.949996)**2, 0.9999))}
L2 N2 N3 1.000000e-06
C3 N3 0 Q = {1.000000e-09 * V(N3) / sqrt(1 - min((V(N3)/510998.949996)**2, 0.9999))}
L3 N3 N4 1.000000e-06
C4 N4 0 Q = {1.000000e-09 * V(N4) / sqrt(1 - min((V(N4)/510998.949996)**2, 0.9999))}
L4 N4 N5 1.000000e-06
C5 N5 0 Q = {1.000000e-09 * V(N5) / sqrt(1 - min((V(N5)/510998.949996)**2, 0.9999))}
L5 N5 N6 1.000000e-06
C6 N6 0 Q = {1.000000e-09 * V(N6) / sqrt(1 - min((V(N6)/510998.949996)**2, 0.9999))}
L6 N6 N7 1.000000e-06
C7 N7 0 Q = {1.000000e-09 * V(N7) / sqrt(1 - min((V(N7)/510998.949996)**2, 0.9999))}
L7 N7 N8 1.000000e-06
C8 N8 0 Q = {1.000000e-09 * V(N8) / sqrt(1 - min((V(N8)/510998.949996)**2, 0.9999))}
L8 N8 N9 1.000000e-06
C9 N9 0 Q = {1.000000e-09 * V(N9) / sqrt(1 - min((V(N9)/510998.949996)**2, 0.9999))}
L9 N9 N10 1.000000e-06
C10 N10 0 Q = {1.000000e-09 * V(N10) / sqrt(1 - min((V(N10)/510998.949996)**2, 0.9999))}
L10 N10 N11 1.000000e-06
C11 N11 0 Q = {1.000000e-09 * V(N11) / sqrt(1 - min((V(N11)/510998.949996)**2, 0.9999))}
L11 N11 N12 1.000000e-06
C12 N12 0 Q = {1.000000e-09 * V(N12) / sqrt(1 - min((V(N12)/510998.949996)**2, 0.9999))}
L12 N12 N13 1.000000e-06
C13 N13 0 Q = {1.000000e-09 * V(N13) / sqrt(1 - min((V(N13)/510998.949996)**2, 0.9999))}
L13 N13 N14 1.000000e-06
C14 N14 0 Q = {1.000000e-09 * V(N14) / sqrt(1 - min((V(N14)/510998.949996)**2, 0.9999))}
L14 N14 N15 1.000000e-06
C15 N15 0 Q = {1.000000e-09 * V(N15) / sqrt(1 - min((V(N15)/510998.949996)**2, 0.9999))}
L15 N15 N16 1.000000e-06
C16 N16 0 Q = {1.000000e-09 * V(N16) / sqrt(1 - min((V(N16)/510998.949996)**2, 0.9999))}
L16 N16 N17 1.000000e-06
C17 N17 0 Q = {1.000000e-09 * V(N17) / sqrt(1 - min((V(N17)/510998.949996)**2, 0.9999))}
L17 N17 N18 1.000000e-06
C18 N18 0 Q = {1.000000e-09 * V(N18) / sqrt(1 - min((V(N18)/510998.949996)**2, 0.9999))}
L18 N18 N19 1.000000e-06
C19 N19 0 Q = {1.000000e-09 * V(N19) / sqrt(1 - min((V(N19)/510998.949996)**2, 0.9999))}
L19 N19 N20 1.000000e-06
C20 N20 0 Q = {1.000000e-09 * V(N20) / sqrt(1 - min((V(N20)/510998.949996)**2, 0.9999))}
L20 N20 N21 1.000000e-06
C21 N21 0 Q = {1.000000e-09 * V(N21) / sqrt(1 - min((V(N21)/510998.949996)**2, 0.9999))}
L21 N21 N22 1.000000e-06
C22 N22 0 Q = {1.000000e-09 * V(N22) / sqrt(1 - min((V(N22)/510998.949996)**2, 0.9999))}
L22 N22 N23 1.000000e-06
C23 N23 0 Q = {1.000000e-09 * V(N23) / sqrt(1 - min((V(N23)/510998.949996)**2, 0.9999))}
L23 N23 N24 1.000000e-06
C24 N24 0 Q = {1.000000e-09 * V(N24) / sqrt(1 - min((V(N24)/510998.949996)**2, 0.9999))}
L24 N24 N25 1.000000e-06
C25 N25 0 Q = {1.000000e-09 * V(N25) / sqrt(1 - min((V(N25)/510998.949996)**2, 0.9999))}
L25 N25 N26 1.000000e-06
C26 N26 0 Q = {1.000000e-09 * V(N26) / sqrt(1 - min((V(N26)/510998.949996)**2, 0.9999))}
L26 N26 N27 1.000000e-06
C27 N27 0 Q = {1.000000e-09 * V(N27) / sqrt(1 - min((V(N27)/510998.949996)**2, 0.9999))}
L27 N27 N28 1.000000e-06
C28 N28 0 Q = {1.000000e-09 * V(N28) / sqrt(1 - min((V(N28)/510998.949996)**2, 0.9999))}
L28 N28 N29 1.000000e-06
C29 N29 0 Q = {1.000000e-09 * V(N29) / sqrt(1 - min((V(N29)/510998.949996)**2, 0.9999))}
L29 N29 N30 1.000000e-06
C30 N30 0 Q = {1.000000e-09 * V(N30) / sqrt(1 - min((V(N30)/510998.949996)**2, 0.9999))}
L30 N30 N31 1.000000e-06
C31 N31 0 Q = {1.000000e-09 * V(N31) / sqrt(1 - min((V(N31)/510998.949996)**2, 0.9999))}
L31 N31 N32 1.000000e-06
C32 N32 0 Q = {1.000000e-09 * V(N32) / sqrt(1 - min((V(N32)/510998.949996)**2, 0.9999))}
L32 N32 N33 1.000000e-06
C33 N33 0 Q = {1.000000e-09 * V(N33) / sqrt(1 - min((V(N33)/510998.949996)**2, 0.9999))}
L33 N33 N34 1.000000e-06
C34 N34 0 Q = {1.000000e-09 * V(N34) / sqrt(1 - min((V(N34)/510998.949996)**2, 0.9999))}
L34 N34 N35 1.000000e-06
C35 N35 0 Q = {1.000000e-09 * V(N35) / sqrt(1 - min((V(N35)/510998.949996)**2, 0.9999))}
L35 N35 N36 1.000000e-06
C36 N36 0 Q = {1.000000e-09 * V(N36) / sqrt(1 - min((V(N36)/510998.949996)**2, 0.9999))}
L36 N36 N37 1.000000e-06
C37 N37 0 Q = {1.000000e-09 * V(N37) / sqrt(1 - min((V(N37)/510998.949996)**2, 0.9999))}
L37 N37 N38 1.000000e-06
C38 N38 0 Q = {1.000000e-09 * V(N38) / sqrt(1 - min((V(N38)/510998.949996)**2, 0.9999))}
L38 N38 N39 1.000000e-06
C39 N39 0 Q = {1.000000e-09 * V(N39) / sqrt(1 - min((V(N39)/510998.949996)**2, 0.9999))}
L39 N39 N40 1.000000e-06
C40 N40 0 Q = {1.000000e-09 * V(N40) / sqrt(1 - min((V(N40)/510998.949996)**2, 0.9999))}
Rterm N40 BIAS 31.622777
.ac lin 40 2.339090e+05 3.274727e+06
.control
set numdgt=12
run
wrdata /private/tmp/claude-501/-Users-grantlindblom-AVE-staging/7da0835f-20b5-4ae5-aa06-9ae9eec5721e/scratchpad/wt-spice-phase1/src/scripts/vol_4_engineering/_output/spice_ladder/spice_ladder_rung5_bias_lo.dat v(NA) v(N1) v(N2) v(N3) v(N4) v(N5) v(N6) v(N7) v(N8) v(N9) v(N10) v(N11) v(N12) v(N13) v(N14) v(N15) v(N16) v(N17) v(N18) v(N19) v(N20) v(N21) v(N22) v(N23) v(N24) v(N25) v(N26) v(N27) v(N28) v(N29) v(N30) v(N31) v(N32) v(N33) v(N34) v(N35) v(N36) v(N37) v(N38) v(N39) v(N40)
.endc
.end
