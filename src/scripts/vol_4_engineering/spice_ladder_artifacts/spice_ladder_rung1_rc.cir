* SPICE PHASE-1 rung 1(a) — RC charging transient
* V_C(t) = V0 (1 - exp(-t/RC)); tau = RC = 1.000000e-03 s (R=1000.0, C=1e-06)
V1 IN 0 PWL(0 0 1p 1 1 1)
R1 IN NC 1.000000e+03
C1 NC 0 1.000000e-06
.tran 2.000000e-06 6.000000e-03 uic
.control
run
wrdata /private/tmp/claude-501/-Users-grantlindblom-AVE-staging/7da0835f-20b5-4ae5-aa06-9ae9eec5721e/scratchpad/wt-spice-phase1/src/scripts/vol_4_engineering/_output/spice_ladder/spice_ladder_rung1_rc.dat v(NC)
.endc
.end
