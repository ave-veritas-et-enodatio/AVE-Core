* SPICE PHASE-1 rung 4 — 1D LC-ladder dispersion
* 40 cells, L=1.000000e-06 H, C=1.000000e-09 F, Zc=31.6228 ohm
* omega_0 = 1/sqrt(LC) = 3.162278e+07 rad/s
V1 N0 0 AC 1
Rs N0 NA 31.622777
L0 NA N1 1.000000e-06
C0 NA 0 1.000000e-09
L1 N1 N2 1.000000e-06
C1 N1 0 1.000000e-09
L2 N2 N3 1.000000e-06
C2 N2 0 1.000000e-09
L3 N3 N4 1.000000e-06
C3 N3 0 1.000000e-09
L4 N4 N5 1.000000e-06
C4 N4 0 1.000000e-09
L5 N5 N6 1.000000e-06
C5 N5 0 1.000000e-09
L6 N6 N7 1.000000e-06
C6 N6 0 1.000000e-09
L7 N7 N8 1.000000e-06
C7 N7 0 1.000000e-09
L8 N8 N9 1.000000e-06
C8 N8 0 1.000000e-09
L9 N9 N10 1.000000e-06
C9 N9 0 1.000000e-09
L10 N10 N11 1.000000e-06
C10 N10 0 1.000000e-09
L11 N11 N12 1.000000e-06
C11 N11 0 1.000000e-09
L12 N12 N13 1.000000e-06
C12 N12 0 1.000000e-09
L13 N13 N14 1.000000e-06
C13 N13 0 1.000000e-09
L14 N14 N15 1.000000e-06
C14 N14 0 1.000000e-09
L15 N15 N16 1.000000e-06
C15 N15 0 1.000000e-09
L16 N16 N17 1.000000e-06
C16 N16 0 1.000000e-09
L17 N17 N18 1.000000e-06
C17 N17 0 1.000000e-09
L18 N18 N19 1.000000e-06
C18 N18 0 1.000000e-09
L19 N19 N20 1.000000e-06
C19 N19 0 1.000000e-09
L20 N20 N21 1.000000e-06
C20 N20 0 1.000000e-09
L21 N21 N22 1.000000e-06
C21 N21 0 1.000000e-09
L22 N22 N23 1.000000e-06
C22 N22 0 1.000000e-09
L23 N23 N24 1.000000e-06
C23 N23 0 1.000000e-09
L24 N24 N25 1.000000e-06
C24 N24 0 1.000000e-09
L25 N25 N26 1.000000e-06
C25 N25 0 1.000000e-09
L26 N26 N27 1.000000e-06
C26 N26 0 1.000000e-09
L27 N27 N28 1.000000e-06
C27 N27 0 1.000000e-09
L28 N28 N29 1.000000e-06
C28 N28 0 1.000000e-09
L29 N29 N30 1.000000e-06
C29 N29 0 1.000000e-09
L30 N30 N31 1.000000e-06
C30 N30 0 1.000000e-09
L31 N31 N32 1.000000e-06
C31 N31 0 1.000000e-09
L32 N32 N33 1.000000e-06
C32 N32 0 1.000000e-09
L33 N33 N34 1.000000e-06
C33 N33 0 1.000000e-09
L34 N34 N35 1.000000e-06
C34 N34 0 1.000000e-09
L35 N35 N36 1.000000e-06
C35 N35 0 1.000000e-09
L36 N36 N37 1.000000e-06
C36 N36 0 1.000000e-09
L37 N37 N38 1.000000e-06
C37 N37 0 1.000000e-09
L38 N38 N39 1.000000e-06
C38 N38 0 1.000000e-09
L39 N39 N40 1.000000e-06
C39 N39 0 1.000000e-09
C40 N40 0 1.000000e-09
Rterm N40 0 31.622777
.ac lin 60 3.019753e+05 8.555966e+06
.control
run
wrdata /private/tmp/claude-501/-Users-grantlindblom-AVE-staging/7da0835f-20b5-4ae5-aa06-9ae9eec5721e/scratchpad/wt-spice-phase1/src/scripts/vol_4_engineering/_output/spice_ladder/spice_ladder_rung4_dispersion.dat v(NA) v(N1) v(N2) v(N3) v(N4) v(N5) v(N6) v(N7) v(N8) v(N9) v(N10) v(N11) v(N12) v(N13) v(N14) v(N15) v(N16) v(N17) v(N18) v(N19) v(N20) v(N21) v(N22) v(N23) v(N24) v(N25) v(N26) v(N27) v(N28) v(N29) v(N30) v(N31) v(N32) v(N33) v(N34) v(N35) v(N36) v(N37) v(N38) v(N39) v(N40)
.endc
.end
